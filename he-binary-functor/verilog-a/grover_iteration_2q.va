// License-ID: SL-AGPL3-001 | Covenant-Version: 1.0 | Project policy reference
// SPDX-License-Identifier: LicenseRef-Sovereign-Leviathan-SL-AGPL3-001
// Main project policy: LICENSES/LicenseRef-Sovereign-Leviathan-SL-AGPL3-001.txt.
// Existing file, component and third-party notices and grants are preserved.

`include "constants.vams"
`include "disciplines.vams"

// =====================================================================
// RAW QUANTUM VERILOG-A GROVER ITERATION (2-Qubit Physical Layer)
// Continuous-time analog modeling of probability amplitudes
// =====================================================================

module grover_iteration_2q (
    input electrical clk_drive,
    input electrical collapse_cmd,
    output electrical amp_00,
    output electrical amp_01,
    output electrical amp_10,
    output electrical amp_11
);

    parameter real VTH = 0.5;
    parameter integer TARGET_STATE = 3;
    parameter real TR = 100p;

    real a[0:3];
    real mean_val;
    integer i;

    analog begin
        @(initial_step) begin
            a[0] = 0.5;
            a[1] = 0.5;
            a[2] = 0.5;
            a[3] = 0.5;
        end

        @(cross(V(clk_drive) - VTH, +1)) begin
            a[TARGET_STATE] = -a[TARGET_STATE];
            mean_val = (a[0] + a[1] + a[2] + a[3]) / 4.0;
            for (i = 0; i < 4; i = i + 1) begin
                a[i] = 2.0 * mean_val - a[i];
            end
        end

        @(cross(V(collapse_cmd) - VTH, +1)) begin
            real max_amp;
            integer max_idx;
            max_amp = -1.0;
            max_idx = 0;

            for (i = 0; i < 4; i = i + 1) begin
                if (abs(a[i]) > max_amp) begin
                    max_amp = abs(a[i]);
                    max_idx = i;
                end
            end

            for (i = 0; i < 4; i = i + 1) begin
                a[i] = (i == max_idx) ? 1.0 : 0.0;
            end
        end

        V(amp_00) <+ transition(a[0], 0, TR, TR);
        V(amp_01) <+ transition(a[1], 0, TR, TR);
        V(amp_10) <+ transition(a[2], 0, TR, TR);
        V(amp_11) <+ transition(a[3], 1n, TR, TR);
    end
endmodule
